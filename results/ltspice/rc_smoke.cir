AirDesk RC smoke: one time constant should reach 1-exp(-1)
V1 in 0 PULSE(0 1 0 1n 1n 10m 20m)
R1 in out 1k
C1 out 0 1u
.tran 0 5m 0 1u uic
.meas tran at_tau FIND V(out) AT=1m
.end
